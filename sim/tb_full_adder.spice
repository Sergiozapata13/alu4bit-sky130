* ============================================================
* Testbench: Full Adder - verificacion funcional + delay/potencia
* (revision 3: estimulos digitales limpios, ver nota abajo)
* ============================================================
.include ../schematics/full_adder_28t.spice

* --- Modelos Sky130 ---
* IMPORTANTE: ngspice no expande variables de entorno tipo $::VAR dentro
* de .lib (esa sintaxis es de HSPICE). Ajustar esta ruta literal a la que
* imprima: find ~/.ciel -path "*sky130A/libs.tech/ngspice*"
.lib "/home/segio/.ciel/ciel/sky130/versions/1689ac3f2dc763876eaf967227c7dfe831b031ae/sky130A/libs.tech/ngspice/sky130.lib.spice" tt

.param VDD_VAL=1.8
.param CLOAD=10f
.param TSTEP=2n

* NOTA DE REDISENO (importante, corrige un bug que paso desapercibido en
* las versiones anteriores de este testbench):
* Los estimulos PWL previos tenian puntos separados por 16ns con valores
* distintos y NINGUNA pareja de puntos cercanos entre ellos, asi que
* ngspice interpolaba LINEALMENTE entre esos dos puntos -> A, B y Cin no
* eran senales digitales (0V/1.8V sostenidos con transiciones rapidas),
* sino ondas TRIANGULARES que tardaban hasta 16ns en cruzar de un nivel
* a otro. Eso por si solo puede producir el aspecto "glitcheado" en las
* salidas (las puertas reciben entradas analogicas rampeando lentamente
* por la zona de transicion durante mucho tiempo), independientemente de
* si la topologia del circuito es correcta o no.
*
* Esta version usa un patron de contador binario: A cambia cada 16ns,
* B cada 32ns, Cin cada 64ns, y CADA transicion es rapida (0.1ns) y se
* sostiene limpia durante el resto de su ventana de 16ns. Con esto se
* aisla el comportamiento del circuito de cualquier artefacto del
* estimulo.
*
* Secuencia de combinaciones (A,B,Cin), cada una sostenida 16ns:
*   [0,16)    000    [16,32)   100    [32,48)   010    [48,64)   110
*   [64,80)   001    [80,96)   101    [96,112)  011    [112,128) 111

* --- Estimulos: contador binario limpio, transicion de 0.1ns ---
VA a vss PWL(
+ 0       0
+ 16n     0
+ 16.1n   {VDD_VAL}
+ 32n     {VDD_VAL}
+ 32.1n   0
+ 48n     0
+ 48.1n   {VDD_VAL}
+ 64n     {VDD_VAL}
+ 64.1n   0
+ 80n     0
+ 80.1n   {VDD_VAL}
+ 96n     {VDD_VAL}
+ 96.1n   0
+ 112n    0
+ 112.1n  {VDD_VAL}
+ 128n    {VDD_VAL}
+ )

VB b vss PWL(
+ 0       0
+ 16n     0
+ 32n     0
+ 32.1n   {VDD_VAL}
+ 48n     {VDD_VAL}
+ 64n     {VDD_VAL}
+ 64.1n   0
+ 80n     0
+ 96n     0
+ 96.1n   {VDD_VAL}
+ 112n    {VDD_VAL}
+ 128n    {VDD_VAL}
+ )

VCIN cin vss PWL(
+ 0       0
+ 16n     0
+ 32n     0
+ 48n     0
+ 64n     0
+ 64.1n   {VDD_VAL}
+ 80n     {VDD_VAL}
+ 96n     {VDD_VAL}
+ 112n    {VDD_VAL}
+ 128n    {VDD_VAL}
+ )

VDD vdd 0 DC {VDD_VAL}
VSS vss 0 DC 0

* --- DUT ---
Xfa a b cin sum cout vdd vss full_adder_28t

* --- Cargas capacitivas en las salidas ---
Csum sum vss {CLOAD}
Ccout cout vss {CLOAD}

* --- Analisis ---
.tran {TSTEP} 128n

* --- Mediciones de delay (cruce 50% VDD), acotadas con TD= y con el
*     sentido correcto (RISE/FALL) de cada senal en cada transicion,
*     verificado en Python contra la tabla de verdad -- ver historial.
*     No todas las transiciones de A mueven Sum/Cout (ej. en 32n y 96n
*     ninguna de las dos cambia), asi que se eligen solo las
*     transiciones donde SI hay una respuesta que medir. ---

* t=16n: A 0->1, Sum 0->1 (RISE), Cout no cambia
.meas tran tpd_a_sum_r TRIG v(a) VAL={VDD_VAL/2} RISE=1 TD=15n TARG v(sum) VAL={VDD_VAL/2} RISE=1 TD=15n

* t=48n: A 0->1, Sum 1->0 (FALL), Cout 0->1 (RISE)
.meas tran tpd_a_sum_f  TRIG v(a) VAL={VDD_VAL/2} RISE=1 TD=47n TARG v(sum)  VAL={VDD_VAL/2} FALL=1 TD=47n
.meas tran tpd_a_cout_r TRIG v(a) VAL={VDD_VAL/2} RISE=1 TD=47n TARG v(cout) VAL={VDD_VAL/2} RISE=1 TD=47n

* t=64n: A 1->0, Sum 0->1 (RISE), Cout 1->0 (FALL)
.meas tran tpd_a_sum_r2 TRIG v(a) VAL={VDD_VAL/2} FALL=1 TD=63n TARG v(sum)  VAL={VDD_VAL/2} RISE=1 TD=63n
.meas tran tpd_a_cout_f TRIG v(a) VAL={VDD_VAL/2} FALL=1 TD=63n TARG v(cout) VAL={VDD_VAL/2} FALL=1 TD=63n

* --- Potencia dinamica promedio ---
.meas tran avg_power AVG PAR('-i(VDD)*VDD_VAL') FROM=0 TO=128n

* --- Chequeo de glitch: min/max de cada salida en cada ventana estable
*     (deben quedar cerca de 0V o 1.8V, sin valores intermedios) ---
.meas tran sum_00  FIND v(sum)  AT=8n
.meas tran cout_00 FIND v(cout) AT=8n
.meas tran sum_10  FIND v(sum)  AT=24n
.meas tran cout_10 FIND v(cout) AT=24n
.meas tran sum_01  FIND v(sum)  AT=40n
.meas tran cout_01 FIND v(cout) AT=40n
.meas tran sum_11  FIND v(sum)  AT=56n
.meas tran cout_11 FIND v(cout) AT=56n
.meas tran sum_001 FIND v(sum)  AT=72n
.meas tran cout_001 FIND v(cout) AT=72n
.meas tran sum_101 FIND v(sum)  AT=88n
.meas tran cout_101 FIND v(cout) AT=88n
.meas tran sum_011 FIND v(sum)  AT=104n
.meas tran cout_011 FIND v(cout) AT=104n
.meas tran sum_111 FIND v(sum)  AT=120n
.meas tran cout_111 FIND v(cout) AT=120n

.control
run
plot v(a) v(b) v(cin) v(sum) v(cout)
print tpd_a_sum_r tpd_a_sum_f tpd_a_sum_r2 tpd_a_cout_r tpd_a_cout_f avg_power
.endc

.end
