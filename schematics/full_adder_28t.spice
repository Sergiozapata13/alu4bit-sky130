* ============================================================
* Full Adder CMOS estatico complementario - Sky130
* (revision 2: XOR de transmission-gate, ver nota de rediseno abajo)
* ============================================================
* Ecuaciones:
*   Sum  = A xor B xor Cin
*   Cout = A.B + Cin.(A xor B)
*
* NOTA DE REDISENO (importante):
* La primera version de este full adder usaba un XOR de 12T con redes
* AOI: pull-down/pull-up complementarios donde una rama usaba A,B
* directas y la otra rama usaba A',B' generadas por inversores locales.
* Al simular contra el PDK real de Sky130 (con capacitancias e
* impedancias reales, no los modelos genericos simplificados usados en
* la primera verificacion), esa topologia mostro glitches severos en
* Sum y Cout cada vez que A o B cambiaban: cuando A conmuta, la rama que
* usa A directa reacciona de inmediato, pero la rama que usa A' (generada
* por el inversor local) sigue viendo el valor viejo durante el delay de
* ese inversor. En esa ventana, pull-up y pull-down pueden quedar ambos
* activos (o ambos inactivos) momentaneamente -> contencion -> glitch.
* Como Sum encadena dos de estos XOR, el glitch se duplicaba, y Cout lo
* heredaba porque usa p_ab (la salida ya glitcheada del primer XOR) como
* entrada de su propia red AOI22.
*
* Solucion: XOR de transmission-gate (XOR-TG, ~8T por compuerta). Aqui
* B y B' actuan solo como SELECTORES de un mux de 2 entradas (pasan A o
* A' hacia la salida), nunca como dos redes independientes compitiendo
* por el mismo nodo de salida. Esto elimina la ventana de contencion:
* en todo momento exactamente una de las dos transmission gates esta
* activa (controladas por b/b' que son complementarias por construccion
* de un solo inversor), y la que pasa el dato correcto al nodo de salida.
*
* Verificado en Python (tabla de verdad completa) antes de escribir el
* netlist -- ver historial del proyecto.
* ============================================================

.subckt inv_sk130 in out vdd vss
Xp1 out in vdd vdd sky130_fd_pr__pfet_01v8 l=0.15 w=0.84
Xn1 out in vss vss sky130_fd_pr__nfet_01v8 l=0.15 w=0.42
.ends inv_sk130

* ------------------------------------------------------------
* XOR de transmission-gate (XOR-TG), ~8T:
*   out = A si B=0 (TG1 pasa A, controlada por b_n/b)
*   out = A' si B=1 (TG2 pasa A', controlada por b/b_n)
* B y B' son las UNICAS senales de control; A y A' son los datos que
* se conmutan hacia la salida. No hay dos redes compitiendo por el
* mismo nodo: en cualquier instante solo una TG conduce.
* ------------------------------------------------------------
.subckt xor2_sk130 a b out vdd vss
* Inversores de control: generan A' y B'
Xp_ainv a_n a vdd vdd sky130_fd_pr__pfet_01v8 l=0.15 w=0.84
Xn_ainv a_n a vss vss sky130_fd_pr__nfet_01v8 l=0.15 w=0.42
Xp_binv b_n b vdd vdd sky130_fd_pr__pfet_01v8 l=0.15 w=0.84
Xn_binv b_n b vss vss sky130_fd_pr__nfet_01v8 l=0.15 w=0.42

* TG1: pasa A hacia out cuando B=0 (ctrl = b_n para nmos, b para pmos)
* CORRECCION DE ORDEN DE TERMINALES: sky130_fd_pr__Xfet_01v8 espera
* d g s b. Aqui el CONTROL (b_n/b) va en la posicion de GATE y el DATO
* (a) en drain/source -- version anterior tenia esto invertido (dato
* en gate, control en source), lo cual "accidentalmente" daba la
* funcion booleana correcta para entradas puramente digitales (0/VDD)
* pero no es una transmission gate real (fallaba con valores
* intermedios, encontrado al depurar el mux de la ALU top-level). Ver
* historial del proyecto para el detalle completo de este hallazgo.
Xn_tg1a out b_n a vss sky130_fd_pr__nfet_01v8 l=0.15 w=0.42
Xp_tg1a out b a vdd sky130_fd_pr__pfet_01v8 l=0.15 w=0.84

* TG2: pasa A' hacia out cuando B=1 (ctrl = b para nmos, b_n para pmos)
Xn_tg2a out b a_n vss sky130_fd_pr__nfet_01v8 l=0.15 w=0.42
Xp_tg2a out b_n a_n vdd sky130_fd_pr__pfet_01v8 l=0.15 w=0.84
.ends xor2_sk130

* ------------------------------------------------------------
* Full Adder top: compone Sum a partir de dos XOR-TG en cascada,
* y Cout con una compuerta AOI22 (genera el complemento) + inversor
* final. La red AOI22 usa A, B, Cin, p_ab DIRECTAMENTE (no genera ni
* usa inversos locales de estas senales), asi que no sufre el mismo
* problema de skew que tenia el XOR de 12T original.
*
*   Cout_n = NOT( A.B + Cin.p_ab )   <- red pull-down activa AQUI
*   Cout   = NOT( Cout_n )           <- inversor de salida
* ------------------------------------------------------------
.subckt full_adder_28t A B Cin Sum Cout vdd vss
Xxor1 A B p_ab vdd vss xor2_sk130
Xxor2 p_ab Cin Sum vdd vss xor2_sk130

* Red pull-down: Cout_n=0 (fuerte) cuando A.B=1 O Cin.p_ab=1
Xn_c1 cout_n A n_c1 vss sky130_fd_pr__nfet_01v8 l=0.15 w=0.42
Xn_c2 n_c1 B vss vss sky130_fd_pr__nfet_01v8 l=0.15 w=0.42
Xn_c3 cout_n Cin n_c2 vss sky130_fd_pr__nfet_01v8 l=0.15 w=0.42
Xn_c4 n_c2 p_ab vss vss sky130_fd_pr__nfet_01v8 l=0.15 w=0.42

* Red pull-up: dual serie-paralelo CORRECTA de la red anterior.
* La pull-down es (A serie B) OR (Cin serie p_ab); su dual (para que
* cout_n = NOT de la funcion) es (A paralelo B) EN SERIE CON
* (Cin paralelo p_ab) -- cada serie del pull-down se vuelve paralelo en
* el pull-up y viceversa, usando las MISMAS variables (no complementadas,
* porque el PMOS ya conduce con gate=0).
*
* (Una version anterior cruzaba las variables -- A con Cin, B con p_ab --
* en dos ramas serie independientes. Esa red no es la dual correcta: deja
* la combinacion A=1,B=0,Cin=0 sin pull-up NI pull-down activos, con
* cout_n flotando en un voltaje intermedio en vez de un nivel logico
* limpio. Verificado con las 8 combinaciones en Python antes de corregir
* -- ver historial del proyecto.)
Xp_a cout_n A m1 vdd sky130_fd_pr__pfet_01v8 l=0.15 w=0.84
Xp_b cout_n B m1 vdd sky130_fd_pr__pfet_01v8 l=0.15 w=0.84
Xp_cin m1 Cin vdd vdd sky130_fd_pr__pfet_01v8 l=0.15 w=0.84
Xp_pab m1 p_ab vdd vdd sky130_fd_pr__pfet_01v8 l=0.15 w=0.84

* Inversor de salida: Cout = NOT(cout_n)
Xp_out Cout cout_n vdd vdd sky130_fd_pr__pfet_01v8 l=0.15 w=0.84
Xn_out Cout cout_n vss vss sky130_fd_pr__nfet_01v8 l=0.15 w=0.42
.ends full_adder_28t
