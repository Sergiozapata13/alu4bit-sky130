* ============================================================
* Full Adder CMOS estatico complementario (28T) - Sky130
* ============================================================
* Ecuaciones:
*   Sum  = A xor B xor Cin
*   Cout = A.B + Cin.(A xor B)
*
* Implementacion clasica de 3 etapas de compuertas complementarias:
*   XOR1: P = A xor B          (usada tambien para Cout)
*   XOR2: Sum = P xor Cin
*   AOI/OAI para Cout a partir de A, B, Cin, P
*
* Cada compuerta se arma como red pull-up (PMOS) / pull-down (NMOS)
* complementaria de tamano minimo (W=0.42u L=0.15u tipico sky130A,
* ajustar segun PDK real instalado). Sizing inicial 1x; se afina
* en Fase 4 (caracterizacion).
* ============================================================

.subckt inv_sk130 in out vdd vss
Mp1 out in vdd vdd sky130_fd_pr__pfet_01v8 W=0.84 L=0.15
Mn1 out in vss vss sky130_fd_pr__nfet_01v8 W=0.42 L=0.15
.ends inv_sk130

* Compuerta XOR de 2 entradas, estilo CMOS complementario (12T)
* out = A xor B
.subckt xor2_sk130 a b out vdd vss
* Inversores locales para A' y B'
Mp_ainv out_ainv a vdd vdd sky130_fd_pr__pfet_01v8 W=0.84 L=0.15
Mn_ainv out_ainv a vss vss sky130_fd_pr__nfet_01v8 W=0.42 L=0.15
Mp_binv out_binv b vdd vdd sky130_fd_pr__pfet_01v8 W=0.84 L=0.15
Mn_binv out_binv b vss vss sky130_fd_pr__nfet_01v8 W=0.42 L=0.15

* Red pull-down: out=0 cuando (A=1,B=1) o (A=0,B=0)
Mn1 out a n1 vss sky130_fd_pr__nfet_01v8 W=0.42 L=0.15
Mn2 n1 b vss vss sky130_fd_pr__nfet_01v8 W=0.42 L=0.15
Mn3 out out_ainv n2 vss sky130_fd_pr__nfet_01v8 W=0.42 L=0.15
Mn4 n2 out_binv vss vss sky130_fd_pr__nfet_01v8 W=0.42 L=0.15

* Red pull-up: out=1 cuando (A=1,B=0) o (A=0,B=1)
Mp1 out a p1 vdd sky130_fd_pr__pfet_01v8 W=0.84 L=0.15
Mp2 p1 out_binv vdd vdd sky130_fd_pr__pfet_01v8 W=0.84 L=0.15
Mp3 out out_ainv p2 vdd sky130_fd_pr__pfet_01v8 W=0.84 L=0.15
Mp4 p2 b vdd vdd sky130_fd_pr__pfet_01v8 W=0.84 L=0.15
.ends xor2_sk130

* ------------------------------------------------------------
* Full Adder top: compone Sum a partir de dos XOR en cascada,
* y Cout con una compuerta AOI22 (genera el complemento) + inversor
* final, que es la forma correcta de implementar una funcion OR-de-
* ANDs en logica CMOS estatica de una sola etapa:
*
*   Cout_n = NOT( A.B + Cin.p_ab )   <- red pull-down activa AQUI
*   Cout   = NOT( Cout_n )           <- inversor de salida
*
* (la version anterior conectaba la red activa directo a Cout, lo
*  cual producia el complemento de la funcion deseada; con el
*  inversor final se corrige sin cambiar la topologia AOI de base)
* ------------------------------------------------------------
.subckt full_adder_28t A B Cin Sum Cout vdd vss
Xxor1 A B p_ab vdd vss xor2_sk130
Xxor2 p_ab Cin Sum vdd vss xor2_sk130

* Red pull-down: Cout_n=0 (fuerte) cuando A.B=1 O Cin.p_ab=1
Mn_c1 cout_n A n_c1 vss sky130_fd_pr__nfet_01v8 W=0.42 L=0.15
Mn_c2 n_c1 B vss vss sky130_fd_pr__nfet_01v8 W=0.42 L=0.15
Mn_c3 cout_n Cin n_c2 vss sky130_fd_pr__nfet_01v8 W=0.42 L=0.15
Mn_c4 n_c2 p_ab vss vss sky130_fd_pr__nfet_01v8 W=0.42 L=0.15

* Red pull-up: dual serie-paralelo de la red anterior (AOI22 estandar)
Mp_c1 cout_n A p_c1 vdd sky130_fd_pr__pfet_01v8 W=0.84 L=0.15
Mp_c2 p_c1 Cin vdd vdd sky130_fd_pr__pfet_01v8 W=0.84 L=0.15
Mp_c3 cout_n B p_c2 vdd sky130_fd_pr__pfet_01v8 W=0.84 L=0.15
Mp_c4 p_c2 p_ab vdd vdd sky130_fd_pr__pfet_01v8 W=0.84 L=0.15

* Inversor de salida: Cout = NOT(cout_n)
Mp_out Cout cout_n vdd vdd sky130_fd_pr__pfet_01v8 W=0.84 L=0.15
Mn_out Cout cout_n vss vss sky130_fd_pr__nfet_01v8 W=0.42 L=0.15
.ends full_adder_28t
